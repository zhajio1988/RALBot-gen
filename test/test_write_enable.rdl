// parallel interface write enable example
//
// parameter defines for this example
//

mem fixed_mem #(longint unsigned word_size = 32,
    longint unsigned memory_size = word_size * 4096) {
    mementries = memory_size / word_size ;
    memwidth = word_size ;
};
addrmap foo{
        default reset=0;
		reg {
		   field {sw=rw; hw=r; counter; hwset; hwclr; swwel;} count_fld[8] = 8'h55;
		   field {sw=rw; intr; } intr1;
		   field {sw=rw; intr;} intr2;
		} intr_reg;
		
		reg{
		   field {sw=rw;hw=w;}  log_err[8] =8'h4;
		   field {sw=r;hw=w;}  log_value[8] =8'h0;		   
		} log_reg;		
		
		reg {
		   regwidth=64;
		   field{sw=rw; hw=na;} field64[64];
		} bigreg;
        
        external fixed_mem mem32;
		
		addrmap {
		   reg {
		      field{sw=rw; hw=na;} field32[32];
		   } array_reg[8];
		} childmap_32b @0x100;
} ;


